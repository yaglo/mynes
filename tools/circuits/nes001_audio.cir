* NES-001 audio path: APU pins to the RCA "LINE LEVEL AUDIO OUT" jack.
*
* Motherboard (N. Schenk, NES-001 schematic rev 1.0, 2020-06-05,
* https://github.com/schenkzoola/NES, commit 56e5018491fcc8e0cd591d16a97c8a7b1d723983):
* AD1 (pulses) through R4 100 and R7 20k, AD2 (triangle/noise/DMC) through
* R3 100 and R8 12k, and AUX_AUDIO_IN through R9 20k, sum into C23 1 uF
* into U9E, one gate of a 74HC04 used as an inverting amplifier with
* R6 47k in parallel with C21 220 pF from output to input; C20 220 pF from
* the output to ground; FC1 39 uH and C4 0.01 uF to the AUDIO_OUT pin.
*
* RF/AV module (Electronix Corp. trace, 1992): the AUDIO pin drives Q4
* (2SC1740) whose emitter node carries 7500 to ground, a 3900 towards the
* sound modulator and an 820 drawn to +5 V; a 1 uF/50 V capacitor, a 68 uH
* choke and shunt capacitors (values not legible) reach the jack. The
* follower is taken as a unity buffer with an assumed output resistance,
* and the shunt capacitors as 1 nF each; the TV's line input is R_tv.
*
* The 74HC04 gate is a behavioural inverter with open-loop gain a_ol and
* output resistance r_out (swept; Nexperia gives no fixed figure for the
* unbuffered part in linear use). This is a sensitivity model of a traced
* topology, not a measurement of a console; the numbers to compare with
* are rainwarrior's sweep (NES about 16 Hz single-pole high-pass; nesdev
* thread 17745).

.param a_ol=20 r_out=1k r_tv=47k r_follower=100 src=1

* Sources: src=1 drives the pulse pin, src=2 the TND pin; the other is 0 V.
Vp ad1 0 dc 0 ac {src==1 ? 1 : 0}
Vt ad2 0 dc 0 ac {src==2 ? 1 : 0}
R4 ad1 n4 100
R7 n4 sum 20k
R3 ad2 n3 100
R8 n3 sum 12k
R9 aux sum 20k
Raux aux 0 1G
C23 sum amp_in 1u
* 74HC04 gate: self-biased at Vdd/2 through R6.
B1 amp_o 0 V = 2.5 - a_ol*(V(amp_in) - 2.5)
Ro amp_o out {r_out}
R6 out amp_in 47k
C21 out amp_in 220p
C20 out 0 220p
Lfc1 out mb 39u
C4 mb 0 0.01u
* Module: unity follower with an output resistance, coupling, choke, jack.
E4 e4 0 mb 0 1
Rf e4 e4r {r_follower}
R7500 e4r 0 7500
R3900 e4r 0 3900
Cc e4r j1 1u
Cs1 j1 0 1n
L68 j1 jack 68u
Cs2 jack 0 1n
Rtv jack 0 {r_tv}

.control
set wr_singlescale
set wr_vecnames
ac dec 40 1 200k
wrdata ac.txt vdb(jack) vp(jack) vdb(out)
quit
.endc
.end
