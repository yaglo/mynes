* NES-001 power supply: NES-002 adaptor, bridge, reservoir, 7805, +5 V rail.
*
* Electronix Corp. trace of the RF/AV module, 1992: the NES-002 gives 9 VAC
* at 1.3 A into a bridge (B41 x4), a 2200 uF/15 V reservoir with 0.01 uF
* bypasses, the power switch, then a 7805 with 10 uF/35 V at its input and
* 100 uF/6.3 V and 0.01 uF at its output. The +13 V node before the
* regulator also feeds the RF modulator.
*
* The 7805 is behavioural: 5 V plus the input ripple attenuated by the
* ripple rejection RR (dB) of the TI LM7805 data sheet, 62 dB minimum and
* about 73 dB typical at 120 Hz with the input above the dropout, plus a
* load-regulation output resistance r_load (10 milliohm, from 15 mV over
* 1.5 A). The +5 V load is the console at i_load (swept 0.4 to 0.8 A; not
* measured here), the +13 V load the modulator at 40 mA (assumed).
* Transformer regulation is folded into a 0.8 ohm source resistance
* (assumed). Diodes are generic.

.param rr_db=73 i_load=0.6 i_mod=0.04 r_load=0.01 r_src=0.8 vac=9

Vac ac1 0 sin(0 {vac*1.41421} 60)
Rsrc ac1 ac2 {r_src}
D1 ac2 raw DGEN
D2 0 ac2 DGEN
D3 0 raw_n DGEN
D4 raw_n raw DGEN
Vret raw_n 0 dc 0
Cres raw 0 2200u
Cb1 raw 0 0.01u
Imod raw 0 dc {i_mod}
Cin raw 0 10u
* Regulator: output follows 5 V plus attenuated input ripple, minus load
* regulation; its input draws the output current from the reservoir.
Bvreg reg 0 V = 5 + (V(raw) - 12.0) * pow(10, -rr_db/20)
Vsense reg regs dc 0
Rreg regs five {r_load}
Bin raw 0 I = i(Vsense)
Cout five 0 100u
Cout2 five 0 0.01u
Iload five 0 dc {i_load}

.model DGEN D(IS=1e-9 RS=0.05 N=1.7 BV=100)

.control
set wr_singlescale
set wr_vecnames
tran 20u 0.5 0.4
wrdata tran.txt v(raw) v(five)
quit
.endc
.end
